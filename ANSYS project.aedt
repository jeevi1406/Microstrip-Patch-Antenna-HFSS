# Ansys Electronics Desktop project, version 2025.2
project variables:
  $gap = 4.2mm
  $y2 = 1mm
  $Wf = 3.2mm
  $y1 = 2mm
materials:
  vacuum: permittivity=1
  FR4_epoxy: permittivity=4.4 dielectric_loss_tangent=0.02
  air: permittivity=1.0006 permeability=1.0000004

design Antenna (HFSS, HFSS Modal Network, model units mm)
geometry:
  RadiatingSurface [air] = region(absolute_offset=41.666667mm on all sides)
  Sub1 [FR4_epoxy] = box(corner=((-30/2) mm, (-34/2) mm, 0mm), size=(30mm, 34mm, 1mm))
  left_right1 [vacuum] = rectangle(corner=((-30/2) mm, (-34/2) mm, 1mm), x_size=30mm, y_size=10mm)
  Centre_feed3 = rectangle(corner=(-$gap/2, (-34/2) mm, 1mm), x_size=$gap, y_size=32mm)
  left_right1.subtract(Centre_feed3)
  left_right1.thicken(0mm)
  Ground1 [vacuum] = rectangle(corner=((-30/2) mm, (-34/2) mm, 0mm), x_size=30mm, y_size=10mm)
  Ground1.thicken(0mm)
  Excitation1 = rectangle(corner=((-3.2/2) mm, (-34/2) mm, 0mm), z_size=1mm, x_size=3.2mm)
  Centre_feed2 [vacuum] = rectangle(corner=(-$Wf/2, (-34/2) mm, 1mm), x_size=$Wf, y_size=32mm)
  Panel_6 = rectangle(corner=((-20/2) mm, 2mm, 1mm), x_size=20mm, y_size=$y1)
  Panel_5 = rectangle(corner=((-18/2) mm, 7mm, 1mm), x_size=18mm, y_size=$y2)
  Panel_4 = rectangle(corner=((-15/2) mm, (28/2) mm, 1mm), x_size=15mm, y_size=$y2)
  Centre_feed2.unite(Panel_6, Panel_5, Panel_4)
  Centre_feed2.thicken(0mm)
boundaries and excitations:
  Open1: Radiation Objects=RadiatingSurface
  PerfE4: Perfect E Objects=left_right1
  PerfE5: Perfect E Objects=Ground1
  PerfE6: Perfect E Objects=Centre_feed2
  2: Lumped Port Objects=Excitation1 LumpedPortType=Modal Modes{Mode1{IntLine{(0, -17, 0) -> (0, -17, 1)} CharImp=Zpi RenormImp=50ohm}} Impedance=50ohm
setups:
  Setup1: HfssDriven Frequency=2.4GHz MaxDeltaS=0.02 MaximumPasses=10 MinimumPasses=1 MinimumConvergedPasses=1 PercentRefinement=30 BasisOrder=1 PortAccuracy=2 DrivenSolverType="Direct Solver"
    sweep Sweep: 1GHz to 5GHz, 401 points; Type=Interpolating SaveFields InterpTolerance=0.5 InterpMaxSolns=250 InterpUsePortImped=false PassivityErrorTolerance=0.0001
source amplitudes:
  2:1: 1W 0deg
radiation setups:
  Infinite Sphere1: Infinite Sphere Theta=0deg..360deg step 2deg Phi=0deg..360deg step 2deg
reports:
  Return Loss: dB(S(2,2)) vs Freq on Setup1 : Sweep; markers MX1 at x=2.4e+09, MX2 at x=4.3e+09, MY1 at y=-10
  Impedance: mag(Z(2,2)) vs Freq on Setup1 : Sweep
  VSWR: VSWR(2) vs Freq on Setup1 : Sweep; markers MX1 at x=2.4e+09, MX2 at x=4.3e+09, MY1 at y=2
  Radiation pattern: dB(GainTotal) vs Theta on Setup1 : LastAdaptive, Infinite Sphere1 [Phi=0deg Freq=2.4GHz]
  Gain: dB(GainTotal) vs Phi, Theta on Setup1 : LastAdaptive, Infinite Sphere1 [Freq=2.4GHz]
